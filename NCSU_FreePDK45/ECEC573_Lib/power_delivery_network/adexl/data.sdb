ADE simulation setup
Run mode: Single Run, Sweeps and Corners
Tests:
  ECEC573_Lib:power_delivery_network:1: ECEC573_Lib/power_delivery_network/schematic, simulator spectre
Global variables:
  decap15 = 1a,1a,1a,1a,1a,2p,1a
  decap30 = 1a,1a,1a,1a,1a,1a,2p
  decap = 1a,50f,200f,500f,2p,2p,2p
  decap5 = 1a,50f,200f,500f,2p,1a,1a
  Freq = 600M
  Freq1 = 500M
  Freq2 = 1G
  Freq3 = 750M
