ADE simulation setup
Run mode: Single Run, Sweeps and Corners
Tests:
  ECEC573_Lib:power_delivery_network:1: ECEC573_Lib/power_delivery_network/schematic, simulator spectre
Global variables:
  decap15 = 1a
  decap30 = 1a
  decap = 1a
  decap5 = 1a
  Ipk = 0,iPar("DCCur")
